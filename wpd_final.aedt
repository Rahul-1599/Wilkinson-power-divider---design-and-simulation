# Ansys Electronics Desktop project, version 2025.2
materials:
  vacuum: permittivity=1
  copper: permeability=0.999991 conductivity=58000000
  FR4_epoxy: permittivity=4.4 dielectric_loss_tangent=0.02
  air: permittivity=1.0006 permeability=1.0000004

design HFSSDesign2 (HFSS, HFSS Terminal Network, model units mm)
geometry:
  ground [copper] = box(corner=(0mm, 0mm, 0mm), size=(19mm, 25.4mm, 0.035mm))
  input [copper] = box(corner=(8mm, 0mm, 1.635mm), size=(3mm, 10mm, 0.035mm))
  input1 [copper] = box(corner=(7mm, 8.4mm, 1.635mm), size=(1mm, 1.6mm, 0.035mm))
  input2 [copper] = box(corner=(11mm, 8.4mm, 1.635mm), size=(1mm, 1.6mm, 0.035mm))
  input3 [copper] = box(corner=(5.4mm, 8.4mm, 1.635mm), size=(1.6mm, 7mm, 0.035mm))
  input4 [copper] = box(corner=(12mm, 8.4mm, 1.635mm), size=(1.6mm, 7mm, 0.035mm))
  input5 [copper] = box(corner=(4.7mm, 15.4mm, 1.635mm), size=(3mm, 10mm, 0.035mm))
  input6 [copper] = box(corner=(11.3mm, 15.4mm, 1.635mm), size=(3mm, 10mm, 0.035mm))
  Polyline1 [vacuum] = polyline(z=1.67mm, xy in mm: (12, 8.4) (13.6, 10.15) (13.6, 8.4) (12, 8.4), closed, covered)
  Polyline1.thicken(-0.035mm)
  Polyline2 [vacuum] = polyline(z=1.67mm, xy in mm: (5.4, 10.15) (7, 8.4) (5.4, 8.4) (5.4, 10.15), closed, covered)
  Polyline2.thicken(-0.035mm)
  Rectangle1 [vacuum] = rectangle(corner=(8mm, 0mm, 0mm), z_size=1.635mm, x_size=3mm)
  Rectangle2 = rectangle(corner=(4.7mm, 25.4mm, 0mm), z_size=1.635mm, x_size=3mm)
  Rectangle3 = rectangle(corner=(11.3mm, 25.4mm, 0mm), z_size=1.635mm, x_size=3mm)
  resistor = rectangle(corner=(7mm, 14.4mm, 1.635mm), x_size=5mm, y_size=2mm)
  Rectangle1.thicken(0mm)
  Box1 [FR4_epoxy] = box(corner=(0mm, 0mm, 0.035mm), size=(19mm, 25.4mm, 1.6mm))
  RadiatingSurface [vacuum] = region(absolute_offset=19.230769mm on all sides)
boundaries and excitations:
  LumpRLC1: Lumped RLC Objects=resistor CurrentLine{(12, 15.4, 1.635) -> (7, 15.4, 1.635)} RLC_Type=Serial Resistance=100ohm
  Open1: Radiation Objects=RadiatingSurface
  1: Lumped Port Objects=Rectangle1 LumpedPortType=Modal Modes{Mode1{IntLine{(9.5, 0, 0.035) -> (9500mm, 0mm, 1468.5629mm)} CharImp=Zpi}} Impedance=50ohm
  2: Lumped Port Objects=Rectangle2 LumpedPortType=Modal Modes{Mode1{IntLine{(6.4, 25.4, 0) -> (6400mm, 25400mm, 1566.4671mm)} CharImp=Zpi}} Impedance=50ohm
  3: Lumped Port Objects=Rectangle3 LumpedPortType=Modal Modes{Mode1{IntLine{(13, 25.4, 0) -> (13000mm, 25400mm, 1566.4671mm)} CharImp=Zpi}} Impedance=50ohm
setups:
  Setup1: HfssDriven Frequency=5.2GHz MaxDeltaS=0.01 MaximumPasses=20 MinimumPasses=1 MinimumConvergedPasses=1 PercentRefinement=30 BasisOrder=1 PortAccuracy=2 DrivenSolverType="Direct Solver"
    sweep Sweep: 4GHz to 7.5GHz, 401 points; Type=Interpolating SaveFields InterpTolerance=0.5 InterpMaxSolns=250 PassivityErrorTolerance=0.0001
source amplitudes:
  1:1: 1V 0deg
  2:1, 3:1: 0V 0deg
radiation setups:
  3D: Infinite Sphere Theta=0deg..180deg step 2deg Phi=-180deg..180deg step 2deg
  Elevation: Infinite Sphere Theta=-180deg..180deg step 1deg Phi=0deg..90deg step 90deg
  Azimuth: Infinite Sphere Theta=90deg..90deg step 0deg Phi=-180deg..180deg step 1deg
reports:
  S Parameter Plot1: dB(S(1,1)), dB(S(2,1)), dB(S(3,1)), dB(S(1,2)), dB(S(2,2)), dB(S(3,2)), dB(S(1,3)), dB(S(2,3)), dB(S(3,3)) vs Freq on Setup1 : Sweep
