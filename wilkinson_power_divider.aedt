# Ansys Electronics Desktop project, version 2025.2
materials:
  copper: permeability=0.999991 conductivity=58000000

design Ideal (Circuit)
options: SParamCircuitDef IntegrationMethod=FFT
components:
  A14 = TRLE_NX(E=90deg Z=70.71 F=5.2GHz)
  A15 = TRLE_NX(E=90deg Z=70.71 F=5.2GHz)
  R33 = RES_(R=100)
  port Port1 rz=50ohm iz=0ohm EnableNoise=false noisetemp=16.85cel
  port Port2 rz=50ohm iz=0ohm EnableNoise=false noisetemp=16.85cel
  port Port3 rz=50ohm iz=0ohm EnableNoise=false noisetemp=16.85cel
nets:
  Port1: A15.0, A14.0
  Port2: A14.1, R33.1
  Port3: A15.1, R33.0
setups:
  LinearFrequency: LinearFrequencyData(false, 0.1, false, "", false) SweepDefinition{Variable=Freq Data="LIN 4GHz 7.5GHz 0.01GHz"}
reports:
  S Parameter Plot1: dB(S(Port1,Port1)), dB(S(Port3,Port1)), dB(S(Port2,Port3)) vs Freq on LinearFrequency : LinearFrequency

design Mcr_strip (Circuit)
options: SParamCircuitDef IntegrationMethod=FFT
components:
  A58 = MS_TRL(W=1.61992mm P=8.1mm)
  A1 = MS_TRL(W=1.61992mm P=8.1mm)
  A62 = MS_TRL(W=3.08388mm P=3.87719mm)
  A2 = MS_TRL(W=3.08388mm P=3.87719mm)
  A3 = MS_TRL(W=3.08388mm P=3.87719mm)
  R67 = RES_(R=100)
  port Port1 rz=50ohm iz=0ohm EnableNoise=false noisetemp=16.85cel
  port Port2 rz=50ohm iz=0ohm EnableNoise=false noisetemp=16.85cel
  port Port3 rz=50ohm iz=0ohm EnableNoise=false noisetemp=16.85cel
nets:
  net_1: A58.0, A1.0, A2.1
  net_2: A1.1, A3.0, R67.1
  net_3: A58.1, A62.0, R67.0
  Port1: A2.0
  Port2: A3.1
  Port3: A62.1
setups:
  LinearFrequency1: LinearFrequencyData(false, 0.1, false, "", false) SweepDefinition{Variable=Freq Data="LIN 4GHz 7.5GHz 0.01GHz"}
reports:
  S Parameter Plot1: dB(S(Port1,Port1)), dB(S(Port1,Port2)), dB(S(Port2,Port3)) vs Freq on LinearFrequency1 : LinearFrequency1

design ms_disc. (Circuit)
options: SParamCircuitDef IntegrationMethod=FFT
components:
  A58 = MS_TRL(W=1.61992mm P=6.89382mm)
  A1 = MS_TRL(W=1.61992mm P=6.89382mm)
  A62 = MS_TRL(W=3.08388mm P=3.87719mm)
  A2 = MS_TRL(W=3.08388mm P=3.87719mm)
  A3 = MS_TRL(W=3.08388mm P=3.87719mm)
  R67 = RES_(R=100)
  A70 = MS_TEEC(W3=3.08388mm W1=1.61992mm W2=1.61992mm)
  A77 = NXMSBENDO(W=1.61992mm)
  A78 = NXMSBENDO(W=1.61992mm)
  A4 = MS_TEEC(W1=1.61992mm W2=3.08388mm)
  A5 = MS_TEEC(W1=3.08388mm W2=1.61992mm)
  port Port1 rz=50ohm iz=0ohm EnableNoise=false noisetemp=16.85cel
  port Port2 rz=50ohm iz=0ohm EnableNoise=false noisetemp=16.85cel
  port Port3 rz=50ohm iz=0ohm EnableNoise=false noisetemp=16.85cel
nets:
  net_10: A70.2, A2.1
  net_11: A78.0, A70.0
  net_12: A70.1, A77.1
  net_13: A78.1, A1.0
  net_15: A4.0, A1.1
  net_16: A4.1, A3.0
  net_17: A5.1, A58.1
  net_18: A5.0, A62.0
  net_19: A4.2, R67.1
  net_20: A5.2, R67.0
  net_21: A77.0, A58.0
  Port1: A2.0
  Port2: A3.1
  Port3: A62.1
setups:
  LinearFrequency1: LinearFrequencyData(false, 0.1, false, "", false) SweepDefinition{Variable=Freq Data="LIN 1GHz 10GHz 0.02GHz LIN 0GHz 10GHz 0.02GHz"}
reports:
  S Parameter Plot1: dB(S(Port1,Port1)), dB(S(Port1,Port2)), dB(S(Port2,Port3)) vs Freq on LinearFrequency1 : LinearFrequency1; markers m1 at 5.14GHz

design Tuning (Circuit)
options: SParamCircuitDef IntegrationMethod=FFT
variables:
  p = 7.99382mm
  l = 6.7mm  # tune 3.99691mm..11.99073mm
  w = 1.133944mm  # tune 0.80996mm..2.42988mm
components:
  A4 = MS_TRL(W=w P=l)
  A5 = MS_TRL(W=w P=l)
  A6 = MS_TRL(W=3.08388mm P=3.87719mm)
  A7 = MS_TRL(W=3.08388mm P=3.87719mm)
  A8 = MS_TRL(W=3.08388mm P=3.87719mm)
  R1 = RES_(R=100)
  A9 = MS_TEEC(W3=3.08388mm W1=1.61992mm W2=1.61992mm)
  A77 = NXMSBENDO(W=1.61992mm)
  A78 = NXMSBENDO(W=1.61992mm)
  A10 = MS_TEEC(W1=1.61992mm W2=3.08388mm)
  A11 = MS_TEEC(W1=3.08388mm W2=1.61992mm)
  port Port1 rz=50ohm iz=0ohm EnableNoise=false noisetemp=16.85cel
  port Port2 rz=50ohm iz=0ohm EnableNoise=false noisetemp=16.85cel
  port Port3 rz=50ohm iz=0ohm EnableNoise=false noisetemp=16.85cel
nets:
  net_1: A77.1, A9.1
  net_11: A9.2, A7.1
  net_13: A78.1, A5.0
  net_15: A10.0, A5.1
  net_16: A10.1, A8.0
  net_17: A4.1, A11.1
  net_18: A11.0, A6.0
  net_19: A10.2, R1.1
  net_20: A11.2, R1.0
  net_21: A4.0, A77.0
  net_4: A9.0, A78.0
  Port1: A7.0
  Port2: A8.1
  Port3: A6.1
setups:
  LinearFrequency: LinearFrequencyData(false, 0.1, false, "", false) SweepDefinition{Variable=Freq Data="LINC 4GHz 7.5GHz 35"}
optimetrics:
  ParametricSetup1: Parametric UseFastCalculationUpdateAlgo SaveSolutions Sim._Setups=[LinearFrequency]
reports:
  S Parameter Plot1: dB(S(Port1,Port1)), dB(S(Port2,Port1)), dB(S(Port2,Port3)) vs Freq on LinearFrequency : LinearFrequency; markers m1 at 5.4411765GHz, m2 at 5.4411765GHz, m3 at 5.5441176GHz, m4 at 5.2352941GHz, m5 at 5.2352941GHz
